// Example Spectre netlist exercising the C++ projection API.
simulator lang=spectre

parameters vdd=1.8 temp=27

vsup (vdd 0) vsource dc=vdd
r1 (vdd out) resistor r=1k
c1 (out 0) capacitor c=1p

subckt inv (in out vdd vss)
    parameters wn=1u wp=2u
    mn (out in vss vss) nch w=wn l=90n
    mp (out in vdd vdd) pch w=wp l=90n
ends inv

x1 (a y vdd 0) inv wn=2u

model nch bsim4 version=4.5 l=90n
model pch bsim4 version=4.5 l=90n type=p

tranAnalysis tran stop=10n step=10p

save out
ic out=0
