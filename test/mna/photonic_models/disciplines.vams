// Minimal VAMS disciplines for photonic model testing

nature Current
    units = "A";
    access = I;
    abstol = 1e-12;
endnature

nature Voltage
    units = "V";
    access = V;
    abstol = 1e-6;
endnature

discipline electrical
    potential Voltage;
    flow Current;
enddiscipline

nature OpticalElectricField
    units = "V/m";
    access = OptE;
    abstol = 1e-12;
endnature

discipline optical
    potential OpticalElectricField;
enddiscipline
