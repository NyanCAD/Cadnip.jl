* NPN common-emitter stage: base and collector shot noise, parasitic thermal, flicker
Vcc vcc 0 DC 5
Vb b 0 DC 0.7 AC 1
Rc vcc c 4.7k
Q1 c b 0 qn
.model qn npn bf=100 is=1e-15 rb=100 re=1 rc=10 kf=1e-12 af=1
.noise v(c) Vb dec 2 1 1e6
.print noise onoise_spectrum inoise_spectrum
.end
