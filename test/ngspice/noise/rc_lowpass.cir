* RC low-pass: resistor thermal noise shaped by the RC pole
V1 in 0 DC 0 AC 1
R1 in out 10k
C1 out 0 1n
.noise v(out) V1 dec 2 1 1e6
.print noise onoise_spectrum inoise_spectrum
.end
